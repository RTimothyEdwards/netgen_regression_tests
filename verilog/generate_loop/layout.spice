* Expected connections of top.v
.subckt sub2 A[1] A[0] B
.ends

.subckt top y[0] y[1] y[2] y[3] z[3] z[2] z[1] z[0] w[5] w[4] w[3] w[2] w[1] w[0]
Xu0 y[0] y[1] z[0] sub2
Xu1 y[2] y[3] z[1] sub2
Xv0 w[1] w[0] z[3] sub2
Xv1 w[3] w[2] z[3] sub2
Xv2 w[5] w[4] z[3] sub2
.ends
