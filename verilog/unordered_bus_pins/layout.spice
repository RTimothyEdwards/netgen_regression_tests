* Layout
.subckt fab D[0] D[10] D[11] D[1] D[2] D[3] D[4] D[5] D[6] D[7] D[8] D[9] Q
.ends

.subckt top n[0] n[1] n[2] n[3] n[4] n[5] n[6] n[7] n[8] n[9] n[10] n[11] q
X1 n[0] n[10] n[11] n[1] n[2] n[3] n[4] n[5] n[6] n[7] n[8] n[9] q fab
.ends
