* Cell with bus pins sorted alphabetically (contents not given)
.subckt fab D[0] D[10] D[11] D[1] D[2] D[3] D[4] D[5] D[6] D[7] D[8] D[9] Q
.ends
