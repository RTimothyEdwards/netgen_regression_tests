* Cells instanced by top.v
.subckt sub3 A[2] A[1] A[0] B
.ends
.subckt sub2 A[1] A[0] B
.ends
.subckt sub1 A B
.ends
