* Memory cell (contents not given)
.SUBCKT mem A<1> A<0> D VDD! VSS!
.ENDS
