* Leaf cell
.subckt res a b g
M1 a g b g nmos W=1 L=1
.ends
