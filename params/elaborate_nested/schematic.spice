* Schematic:  parameters passed through two levels
.subckt inner a b g W=1
M1 a g b g nmos W='W' L=1
.ends

.subckt mid a b c g S=1
X1 a b g inner W='S*2'
X2 b c g inner W='S*3'
.ends

.subckt top a b c d e g
X1 a b c g mid S=1
X2 c d e g mid S=2
.ends
