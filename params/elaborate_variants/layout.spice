* Layout
.subckt cell a b g
M1 a g b g nmos W=2 L=1
.ends

.subckt top a b c d g
X1 a b g cell
M2 b g c g nmos W=3 L=1
X3 c d g cell
.ends
