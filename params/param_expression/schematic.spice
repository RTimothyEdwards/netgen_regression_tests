* Parameters defined as expressions
.param a=2 b='3*a' L=100 vdd=1.8

.subckt stage m p g L=4
.param w2='L*2'
.param vdd=3.3
M1 m g p g nmos W='w2' L=1
.ends

.subckt top a b c d g
X1 a b g stage
M2 b g c g nmos W='b' L=1
M3 c g d g nmos W='vref' L=1
.ends

.param vref='vdd'
