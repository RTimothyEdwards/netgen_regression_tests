.subckt top A B
X0 A B cap_mim w=7u l=7u
.ends top
