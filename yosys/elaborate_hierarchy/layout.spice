* Layout of top:  three transistors with L = 5, 6, and 7
.subckt top a b[0] b[1] b[2] b[3] g
M1 a g b[0] g nmos W=1 L=5
M2 a g b[1] g nmos W=1 L=6
M3 a g b[2] g nmos W=1 L=7
.ends
