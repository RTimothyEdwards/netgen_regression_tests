* Schematic:  spaces around "=" in properties and parameters
.param sc = 0.5

.subckt top a b c d g
M1 a g b g nmos W= 'pw + sc' L=1
M2 b g c g nmos W = 2 L =1
M3 c g d g nmos W=
+ W= 'pw - sc' L=1
.ends

.param pw =2
