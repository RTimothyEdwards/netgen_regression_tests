* Layout:  inverter with output port "out"
.subckt top in out vdd vss
M1 out in vdd vdd pmos W=2 L=1
M2 out in vss vss nmos W=1 L=1
.ends
